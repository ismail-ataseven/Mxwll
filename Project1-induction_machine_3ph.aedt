# Ansys Electronics Desktop project, version 2017.0
materials:
  D21_50: permeability{BType=normal HUnit=A_per_meter BUnit=tesla curve (0, 0) (140, 0.4) (155, 0.45) (171, 0.5) (191, 0.55) (212, 0.6) (237, 0.65) (267, 0.7) (302, 0.75) (340, 0.8) (380, 0.85) (425, 0.9) (476, 0.95) (536, 1) (602, 1.05) (675, 1.1) (765, 1.15) (880, 1.2) (1020, 1.25) (1200, 1.3) (1450, 1.35) (1740, 1.4) (2160, 1.45) (2800, 1.5) (3850, 1.55) (5290, 1.6) (6920, 1.65) (8800, 1.7) (11000, 1.75) (13800, 1.8) (17300, 1.85) (21400, 1.9) (25000, 1.95) (30000, 2)} core_loss_type="Electrical Steel" core_loss_kh=366 core_loss_kc=0.822 core_loss_ke=0.91 mass_density=7820
  copper: permeability=0.999991 conductivity=58000000 mass_density=8933

design RMxprtDesign1 (RMxprt, Three Phase Induction Motor, model units mm)
machine:
  Machine: FrictionLoss=11W WindLoss=11W ReferenceSpeed=1450rpm NumberOfPoles=2 StrayLossFactor=0.01
  Stator: SkewWidth=0 NumberOfSlots=36 LaminationSectors=3 PressBoardThickness=0mm OuterDiameter=140mm InnerDiameter=78mm Length=250mm StackingFactor=0.95 SteelType=D21_50 SlotType=1
  Rotor: OuterDiameter=76mm InnerDiameter=32mm Length=250mm SteelType=D21_50 NumberOfSlots=28 SlotType=1 SkewWidth=1 CastRotor BottomSlotType=UserDefinedSlot StackingFactor=0.95
  Shaft: MagneticShaft
  Stator Slot: Hs0=2mm Hs1=0mm Hs2=15mm Bs0=1mm Bs1=5mm Bs2=5mm Rs=0mm ToothWidth=0mm
  Stator Winding: WindingType=Whole-Coiled WindingLayers=1 HalfTurnLength=0mm ParallelBranches=1 ConductorsPerSlot=30 CoilPitch=0 EndAdjustment=0mm BaseInnerRadius=10mm TipInnerDiameter=2mm EndClearance=1mm CoilWrap=0mm SlotLiner=1mm WedgeThickness=1mm LayerInsulation=0mm BottomInsulation=0mm LimitedFillFactor=0.75 WdgNumberofPriodicMultipler=1 NumberOfStrands=0 WireWrap=0mm InterturnInsulation=0mm WireDiameter=0.683mm WireWidth=0mm WireThickness=0mm Gauge=21
  Rotor Slot: Hs0=2mm Hs1=0mm Hs2=8mm Bs0=3mm Bs1=4mm Bs2=5mm Rs=0mm Hs01=2mm
  Rotor Winding: BarConductorType=copper EndLength=5mm EndRingWidth=5mm EndRingHeight=5mm EndRingConductorType=copper
setups:
  Setup1: TPIM Motor RatedOutputPower=1100W RatedVoltage=380V RatedSpeed=1450rpm OperatingTemperature=75cel LoadType=ConstPower Frequency=50Hz WindingConnection=0
