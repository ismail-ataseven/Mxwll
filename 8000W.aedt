# Ansys Electronics Desktop project, version 2017.0
materials:
  steel_1010: permittivity=1 permeability{BType=normal HUnit=A_per_meter BUnit=tesla curve (0, 0) (238.7, 0.2003) (318.3, 0.3204) (358.1, 0.40045) (437.7, 0.50055) (477.5, 0.5606) (636.6, 0.7908) (795.8, 0.931) (1114.1, 1.1014) (1273.2, 1.2016) (1591.5, 1.302) (2228.2, 1.4028) (3183.1, 1.524) (4774.6, 1.626) (6366.2, 1.698) (7957.7, 1.73) (15915.5, 1.87) (31831, 1.99) (47746.5, 2.04) (63662, 2.07) (79577.5, 2.095) (159155, 2.2) (318310, 2.4)} conductivity=2000000 lande_g_factor=2 mass_density=7872
  m250-35a
  lead: permeability=0.999983 conductivity=5000000 mass_density=11336
  m250-35aa: permeability{BType=normal HUnit=A_per_meter BUnit=tesla curve (0, 0) (26.8, 0.1) (35.7, 0.2) (41.8, 0.3) (47.5, 0.4) (53.4, 0.5) (60, 0.6) (67.9, 0.7) (77.5, 0.8) (90, 0.9) (107, 1) (133, 1.1) (179, 1.2) (284, 1.3) (642, 1.4) (1810, 1.5) (4030, 1.6) (7290, 1.7) (11700, 1.8)} conductivity=2000000 core_loss_type="Electrical Steel" core_loss_kh=215.77775 core_loss_kc=0.33909564 mass_density=7872
  Alnico5: permeability{BType=normal HUnit=Oe BUnit=gauss curve (-640, 0) (-630, 2500) (-620, 4800) (-610, 6200) (-600, 7250) (-590, 8100) (-580, 8900) (-570, 9300) (-560, 9700) (-550, 9950) (-540, 10200) (-530, 10350) (-520, 10500) (-510, 10600) (-500, 10700) (-490, 10800) (-480, 10900) (-450, 11100) (-400, 11400) (-350, 11600) (-300, 11800) (-250, 12000) (-200, 12150) (-150, 12300) (-100, 12450) (0, 12600)} conductivity=2128000 magnetic_coercivity{Magnitude=-640Oe DirComp1=1 DirComp2=0 DirComp3=0} mass_density=7300
  NdFe45H: permeability=1.0557011 conductivity=625000 magnetic_coercivity{Magnitude=-995000A_per_meter DirComp1=1 DirComp2=0 DirComp3=0} mass_density=7400
  vacuum: permittivity=1
  m250-35aa_2DSF1.012: permeability{BType=normal HUnit=A_per_meter BUnit=tesla curve (0, 0) (26.8, 0.1012) (35.7, 0.202399) (41.8, 0.303599) (47.5, 0.404799) (53.4, 0.505999) (60, 0.607199) (67.9, 0.708399) (77.5, 0.809599) (90, 0.910799) (107, 1.012) (133, 1.1132) (179, 1.2144) (284, 1.3156) (642, 1.41679) (1810, 1.51797) (4030, 1.61914) (7290, 1.72029) (11700, 1.82142) (55800, 2.83276)} conductivity=2000000 core_loss_type="Electrical Steel" core_loss_kh=213.219 core_loss_kc=0.335075 mass_density=7966.46
  steel_1010_2DSF0.950: permeability{BType=normal HUnit=A_per_meter BUnit=tesla curve (0, 0) (238.7, 0.1903) (318.3, 0.3044) (358.1, 0.38045) (437.7, 0.47555) (477.5, 0.5326) (636.6, 0.7513) (795.8, 0.8845) (1114.1, 1.0464) (1273.2, 1.1416) (1591.5, 1.237) (2228.2, 1.3328) (3183.1, 1.448) (4774.6, 1.545) (6366.2, 1.6135) (7957.7, 1.644) (15915.5, 1.7775) (31831, 1.8925) (47746.5, 1.941) (63662, 1.9705) (79577.5, 1.99525) (159155, 2.1) (318310, 2.3) (1909860, 4.3)} conductivity=2000000 mass_density=7478.4
  NdFe45H_2DSF0.909_N: CoordinateSystemType=Cylindrical permeability=1.0557 conductivity=625000 magnetic_coercivity{Magnitude=-995000A_per_meter DirComp1=1 DirComp2=0 DirComp3=0} mass_density=7400
  NdFe45H_2DSF0.909_S: CoordinateSystemType=Cylindrical permeability=1.0557 conductivity=625000 magnetic_coercivity{Magnitude=-995000A_per_meter DirComp1=-1 DirComp2=0 DirComp3=0} mass_density=7400
  copper: permeability=0.999991 conductivity=58000000 mass_density=8933

design RMxprtDesign1 (RMxprt, Adjust-Speed Synchronous Machine, model units mm)
machine:
  Machine: FrictionLoss=12W WindLoss=0W ReferenceSpeed=600rpm NumberOfPoles=20 RotorPosition=true ControlType=3 CircuitType=Y3
  Circuit: TriggerPulseWidth=120deg TransistorDrop=0V DiodeDrop=0V ModulationIndex=0 CarrierFrequencyTimes=0
  Stator: SkewWidth=0 NumberOfSlots=24 LaminationSectors=0 PressBoardThickness=0mm OuterDiameter=290mm InnerDiameter=200mm Length=110mm StackingFactor=0.92 SteelType=m250-35aa SlotType=3
  Rotor: OuterDiameter=197mm InnerDiameter=170mm Length=100mm SteelType=steel_1010 PoleType=1 StackingFactor=0.95
  Shaft:
  Stator Slot: Hs0=1.5mm Hs1=1.5mm Hs2=31mm Bs0=13.18mm Bs1=0mm Bs2=0mm Rs=1.5mm ParallelTooth ToothWidth=13.18mm
  Stator Winding: WindingType=Whole-Coiled WindingLayers=2 ParallelBranches=2 ConductorsPerSlot=120 CoilPitch=1 EndAdjustment=0mm BaseInnerRadius=0mm TipInnerDiameter=0mm EndClearance=0mm CoilWrap=0mm SlotLiner=0.3mm WedgeThickness=0mm LayerInsulation=0mm BottomInsulation=0mm LimitedFillFactor=0.75 WdgNumberofPriodicMultipler=1 NumberOfStrands=0 WireWrap=0mm InterturnInsulation=0mm WireDiameter=1.5mm WireWidth=0mm WireThickness=0mm Gauge=0
  Rotor Pole: Embrace=0.82 Offset=0mm ShaftDiameter=0mm Bridge=0mm Rib=0mm MagnetThickness=4.5mm MagnetWidth=0mm MagnetType=NdFe45H
setups:
  Setup1: ASSM Motor RatedOutputPower=8000W RatedVoltage=280V RatedSpeed=600rpm OperatingTemperature=75cel LoadType=ConstPower RatedPowerFactor=0.75

design Maxwell2DDesign1 (Maxwell 2D, Transient, XY geometry, model units mm)
options: ModelDepth=100mm Multiplier=fractions
variables:
  fractions = 1
geometry:
  Band [vacuum] = user_primitive(RMxprt/Band, DiaGap=198.5mm, DiaYoke=170mm, Length=0mm, SegAngle=1.6666667deg, Fractions=1, HalfAxial=0, InfoCore=0)
  Shaft [vacuum] = user_primitive(RMxprt/Band, DiaGap=198.5mm, DiaYoke=170mm, Length=0mm, SegAngle=1.6666667deg, Fractions=1, HalfAxial=0, InfoCore=100)
  OuterRegion [vacuum] = user_primitive(RMxprt/Band, DiaGap=198.5mm, DiaYoke=290mm, Length=0mm, SegAngle=1.6666667deg, Fractions=fractions, HalfAxial=0, InfoCore=100)
  Tool = user_primitive(RMxprt/Band, DiaGap=198.5mm, DiaYoke=290mm, Length=0mm, SegAngle=1.6666667deg, Fractions=fractions, HalfAxial=0, InfoCore=1)
  Stator [m250-35aa_2DSF1.012] = user_primitive(RMxprt/SlotCore, DiaGap=200mm, DiaYoke=290mm, Length=0mm, Skew=0deg, Slots=24, SlotType=3, Hs0=1.5mm, Hs01=0mm, Hs1=1.5mm, Hs2=31mm, Bs0=13.18mm, Bs1=13.769448mm, Bs2=21.931903mm, Rs=1.5mm, FilletType=0, HalfSlot=0, SegAngle=15deg, LenRegion=0mm, InfoCore=0)
  Coil_0 [copper] = user_primitive(RMxprt/LapCoil, DiaGap=200mm, DiaYoke=290mm, Length=0mm, Skew=0deg, Slots=24, SlotType=3, Hs0=1.5mm, Hs1=1.5mm, Hs2=31mm, Bs0=13.18mm, Bs1=13.769448mm, Bs2=21.931903mm, Rs=1.5mm, FilletType=0, Layers=2, CoilPitch=1, EndExt=0mm, SpanExt=0mm, BendAngle=0deg, SegAngle=10deg, LenRegion=0mm, InfoCoil=2)
  Coil_1..Coil_5 [copper], Coil_6..Coil_23 = Coil_0.duplicate_around_axis(axis=Z, angle=15deg, total=24)
  Coil_0.unite(Coil_6, Coil_12, Coil_18)
  Coil_1.unite(Coil_7, Coil_13, Coil_19)
  Coil_2.unite(Coil_8, Coil_14, Coil_20)
  Coil_3.unite(Coil_9, Coil_15, Coil_21)
  Coil_4.unite(Coil_10, Coil_16, Coil_22)
  Coil_5.unite(Coil_11, Coil_17, Coil_23)
  CoilRe_0 [copper] = user_primitive(RMxprt/LapCoil, DiaGap=200mm, DiaYoke=290mm, Length=0mm, Skew=0deg, Slots=24, SlotType=3, Hs0=1.5mm, Hs1=1.5mm, Hs2=31mm, Bs0=13.18mm, Bs1=13.769448mm, Bs2=21.931903mm, Rs=1.5mm, FilletType=0, Layers=2, CoilPitch=1, EndExt=0mm, SpanExt=0mm, BendAngle=0deg, SegAngle=10deg, LenRegion=0mm, InfoCoil=3)
  CoilRe_0.rotate(axis=Z, angle=-15deg)
  CoilRe_1..CoilRe_5 [copper], CoilRe_6..CoilRe_23 = CoilRe_0.duplicate_around_axis(axis=Z, angle=15deg, total=24)
  CoilRe_0.unite(CoilRe_6, CoilRe_12, CoilRe_18)
  CoilRe_1.unite(CoilRe_7, CoilRe_13, CoilRe_19)
  CoilRe_2.unite(CoilRe_8, CoilRe_14, CoilRe_20)
  CoilRe_3.unite(CoilRe_9, CoilRe_15, CoilRe_21)
  CoilRe_4.unite(CoilRe_10, CoilRe_16, CoilRe_22)
  CoilRe_5.unite(CoilRe_11, CoilRe_17, CoilRe_23)
  Rotor [steel_1010_2DSF0.950] = user_primitive(RMxprt/PMCore, DiaGap=197mm, DiaYoke=170mm, Length=0mm, Poles=20, PoleType=1, Embrace=0.82, ThickMag=4.5mm, WidthMag=0mm, Offset=0mm, Bridge=0mm, Rib=0mm, LenRegion=0mm, InfoCore=0)
  Mag_0 [NdFe45H_2DSF0.909_N] = user_primitive(RMxprt/PMCore, DiaGap=197mm, DiaYoke=170mm, Length=0mm, Poles=20, PoleType=1, Embrace=0.82, ThickMag=4.5mm, WidthMag=0mm, Offset=0mm, Bridge=0mm, Rib=0mm, LenRegion=0mm, InfoCore=2)
  Mag_1 [NdFe45H_2DSF0.909_S], Mag_2 [NdFe45H_2DSF0.909_N], Mag_3 [NdFe45H_2DSF0.909_S], Mag_4 [NdFe45H_2DSF0.909_N], Mag_5..Mag_19 = Mag_0.duplicate_around_axis(axis=Z, angle=18deg, total=20)
  Mag_0.unite(Mag_5, Mag_10, Mag_15)
  Mag_1.unite(Mag_6, Mag_11, Mag_16)
  Mag_2.unite(Mag_7, Mag_12, Mag_17)
  Mag_3.unite(Mag_8, Mag_13, Mag_18)
  Mag_4.unite(Mag_9, Mag_14, Mag_19)
  InnerRegion [vacuum] = user_primitive(RMxprt/PMCore, DiaGap=197mm, DiaYoke=170mm, Length=0mm, Poles=20, PoleType=1, Embrace=0.82, ThickMag=4.5mm, WidthMag=0mm, Offset=0mm, Bridge=0mm, Rib=0mm, LenRegion=0mm, InfoCore=100)
  Tool_1 = Tool.copy()
  Band.subtract(Tool_1)
  Tool_2 = Tool.copy()
  InnerRegion.subtract(Tool_2)
  Tool_3 = Tool.copy()
  Shaft.subtract(Tool_3)
  Tool_4 = Tool.copy()
  Stator.subtract(Tool_4)
  Tool_5 = Tool.copy()
  Coil_0.subtract(Tool_5)
  Tool_6 = Tool.copy()
  Coil_1.subtract(Tool_6)
  Tool_7 = Tool.copy()
  Coil_2.subtract(Tool_7)
  Tool_8 = Tool.copy()
  Coil_3.subtract(Tool_8)
  Tool_9 = Tool.copy()
  Coil_4.subtract(Tool_9)
  Tool_10 = Tool.copy()
  Coil_5.subtract(Tool_10)
  Tool_11 = Tool.copy()
  CoilRe_0.subtract(Tool_11)
  Tool_12 = Tool.copy()
  CoilRe_1.subtract(Tool_12)
  Tool_13 = Tool.copy()
  CoilRe_2.subtract(Tool_13)
  Tool_14 = Tool.copy()
  CoilRe_3.subtract(Tool_14)
  Tool_15 = Tool.copy()
  CoilRe_4.subtract(Tool_15)
  Tool_16 = Tool.copy()
  CoilRe_5.subtract(Tool_16)
  Tool_17 = Tool.copy()
  Rotor.subtract(Tool_17)
  Tool_18 = Tool.copy()
  Mag_0.subtract(Tool_18)
  Tool_19 = Tool.copy()
  Mag_1.subtract(Tool_19)
  Tool_20 = Tool.copy()
  Mag_2.subtract(Tool_20)
  Tool_21 = Tool.copy()
  Mag_3.subtract(Tool_21)
  Mag_4.subtract(Tool)
motion:
  MotionSetup1: Band Move_Type=Rotate Coordinate_System=Global Axis=Z Is_Positive=true InitPos=7.5deg Angular_Velocity=600rpm Objects=Band
  Moving1: Moving Objects=[Shaft, Rotor, Mag_0..Mag_4, InnerRegion]
boundaries and excitations:
  PhA_0: Coil Objects=Coil_0 Conductor_number=60 Winding=PhaseA PolarityType=Positive
  PhARe_0: Coil Objects=CoilRe_1 Conductor_number=60 Winding=PhaseA PolarityType=Negative
  PhB_1: Coil Objects=Coil_1 Conductor_number=60 Winding=PhaseB PolarityType=Positive
  PhBRe_1: Coil Objects=CoilRe_2 Conductor_number=60 Winding=PhaseB PolarityType=Negative
  PhBRe_2: Coil Objects=Coil_2 Conductor_number=60 Winding=PhaseB PolarityType=Negative
  PhB_2: Coil Objects=CoilRe_3 Conductor_number=60 Winding=PhaseB PolarityType=Positive
  PhCRe_3: Coil Objects=Coil_3 Conductor_number=60 Winding=PhaseC PolarityType=Negative
  PhC_3: Coil Objects=CoilRe_4 Conductor_number=60 Winding=PhaseC PolarityType=Positive
  PhC_4: Coil Objects=Coil_4 Conductor_number=60 Winding=PhaseC PolarityType=Positive
  PhCRe_4: Coil Objects=CoilRe_5 Conductor_number=60 Winding=PhaseC PolarityType=Negative
  PhA_5: Coil Objects=Coil_5 Conductor_number=60 Winding=PhaseA PolarityType=Positive
  PhA_23: Coil Objects=CoilRe_0 Conductor_number=60 Winding=PhaseA PolarityType=Positive
  PhaseA: Winding Group Type=Voltage IsSolid=false Current=0A Resistance=0.393743ohm Inductance=2.42275e-005H Voltage="228.619 * sin(2*pi*100*time+20.9338*pi/180)" ParallelBranchesNum=2
  PhaseB: Winding Group Type=Voltage IsSolid=false Current=0A Resistance=0.393743ohm Inductance=2.42275e-005H Voltage="228.619 * sin(2*pi*100*time+20.9338*pi/180-2*pi/3)" ParallelBranchesNum=2
  PhaseC: Winding Group Type=Voltage IsSolid=false Current=0A Resistance=0.393743ohm Inductance=2.42275e-005H Voltage="228.619 * sin(2*pi*100*time+20.9338*pi/180-4*pi/3)" ParallelBranchesNum=2
  Y connection: PhaseA, PhaseB, PhaseC
mesh:
  Length_Coil: LengthBased RefineInside Objects=[Coil_0..Coil_5, CoilRe_0..CoilRe_5] MaxLength=8.92534mm
  Length_Mag: LengthBased RefineInside Objects=[Mag_0..Mag_4] MaxLength=2.25mm
  SurfApprox_Mag: SurfApproxBased Objects=[Mag_0..Mag_4] CurvedSurfaceApproxChoice=ManualSettings SurfDev=0.0985mm NormalDev=15deg
  SurfApprox_Main: SurfApproxBased Objects=[Stator, Rotor, Band, OuterRegion, InnerRegion, Shaft] CurvedSurfaceApproxChoice=ManualSettings SurfDev=0.145mm NormalDev=15deg
  Length_Main: LengthBased RefineInside Objects=[Stator, Rotor, Band, OuterRegion, InnerRegion, Shaft] MaxLength=9.3mm
  initial mesh: MeshMethod=AnsoftTAU
setups:
  Setup1: Transient NonlinearSolverResidual=0.0001 StopTime=0.1s TimeStep=0.0002s FastReachSteadyState FrequencyOfAddedVoltageSource=100Hz InitialTimeStep=0.002s MinTimeStep=0.001s MaxTimeStep=0.003s TimeStepErrTolerance=0.0001
field plots:
  Mag_B1: B over Band, Shaft, OuterRegion, Stator, Coil_0..Coil_5, CoilRe_0..CoilRe_5, Rotor, Mag_0..Mag_4, InnerRegion on Setup1 : Transient at Time=-1
reports:
  Torque: Moving1.Torque vs Time on Setup1 : Transient; markers m1 at 84.4ms
  Currents: Current(PhaseA), Current(PhaseB), Current(PhaseC) vs Time on Setup1 : Transient; markers m1 at 51.4ms
  Induced Voltages: InducedVoltage(PhaseA), InducedVoltage(PhaseB), InducedVoltage(PhaseC) vs Time on Setup1 : Transient; markers m1 at 48.8ms, m2 at 22.4ms
  Flux Linkages: FluxLinkage(PhaseA), FluxLinkage(PhaseB), FluxLinkage(PhaseC) vs Time on Setup1 : Transient; markers m1 at 44.4ms
  Voltages: InputVoltage(PhaseA), InputVoltage(PhaseB), InputVoltage(PhaseC) vs Time on Setup1 : Transient
  Powers: InputVoltage(PhaseA)*Current(PhaseA) + InputVoltage(PhaseB)*Current(PhaseB) + InputVoltage(PhaseC)*Current(PhaseC), Moving1.Speed*Moving1.Torque vs Time on Setup1 : Transient
